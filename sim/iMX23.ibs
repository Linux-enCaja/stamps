| IBIS file imx23.ibs
[IBIS ver]   3.2
[File name]   imx23.ibs
[File Rev]   1.2
[Date]   March 15, 2010
[Source]   Based on TSMC 90LP spice model
[Notes]   Rev History
|   1.0  initial release
|   1.2  3/15/2010
|   1) Changed EMI_A12 model from GPIO33S to EMI
|   2) Changed EMI_CE1N model from GPIO33S to EMI
[Disclaimer]   This information is for modeling purposes only and is not
|   guaranteed.
[Copyright]   Copyright 2009 Freescale
|   Component iMX23
[Component]   iMX23
[Manufacturer]   Freescale
[Package]
| variable   typ   min   max
R_pkg   120m   100m   130m
L_pkg   2.8nH   2.6nH   3.0nH
C_pkg   1.0pF   0.8pF   1.2pF
[Pin]   signal_name   model_name  R_pin   L_pin   C_pin
A1   USB_DM   usb_hs   402.00m   3.46nH   0.78pF
A2   VSSA2   GND   224.00m   2.64nH   0.36pF
A3   VAG   analog   549.00m   3.56nH   0.70pF
A4   XTALI   analog   455.00m   3.33nH   0.67pF
A5   XTALO   analog   597.00m   4.14nH   0.74pF
A6   LINE1_INR   analog   398.00m   2.62nH   0.54pF
A7   HP_VGND   GND   175.00m   2.27nH   0.22pF
A8   LRADC0   analog   439.00m   2.71nH   0.58pF
A9   VDD4P2   POWER   132.00m   2.22nH   0.30pF
A10   LRADC4   analog   604.00m   3.57nH   0.67pF
A11   BATT   analog   384.00m   3.44nH   0.75pF
A12   DCDC_LP   analog   366.00m   3.62nH   0.72pF
A13   DCDC_GND   analog   287.00m   3.81nH   0.29pF
B1   VDDS   POWER   264.00m   3.45nH   0.28pF
B2   USB_DP   usb_hs   520.00m   2.99nH   0.82pF
B3   PSWITCH   analog   522.00m   3.35nH   0.67pF
B4   RTC_XTALI   analog   366.00m   2.35nH   0.63pF
B5   LINE1_INL   analog   468.00m   2.83nH   0.63pF
B6   MIC   analog   342.00m   2.02nH   0.63pF
B7   HPL   analog   385.00m   2.42nH   0.62pF
B8   HPR   analog   462.00m   2.90nH   0.68pF
B9   LRADC1   analog   516.00m   3.35nH   0.76pF
B10   LRADC5   analog   539.00m   3.37nH   0.80pF
B11   DCDC_BATTERY   analog   307.00m   3.05nH   0.75pF
B12   DCDC_VDDA   analog   256.00m   3.10nH   0.26pF
B13   DCDC_LN1   analog   310.00m   2.17nH   1.30pF
C1   SPEAKERN   analog   358.00m   2.22nH   0.74pF
C2   VDDXTAL   analog   368.00m   3.29nH   0.22pF
C3   PWM0   gpio33s   385.00m   2.74nH   0.72pF
C4   RTC_XTALO   analog   353.00m   2.21nH   0.72pF
C5   I2C_SCL   gpio33s   394.00m   2.53nH   0.95pF
C6   I2C_SDA   gpio33s   495.00m   2.96nH   1.16pF
C7   VDDA1   POWER   139.00m   1.29nH   0.19pF
C8   VSSA1   GND   84.00m   0.91nH   0.37pF
C9   LRADC2   analog   467.00m   2.78nH   0.72pF
C10   VDDM   POWER   436.00m   3.37nH   0.25pF
C11   VDAC1   analog   514.00m   3.15nH   0.82pF
C12   PWM4   gpio33s   593.00m   3.47nH   0.69pF
C13   DCDC_VDDIO   analog   259.00m   3.08nH   0.24pF
D1   SPEAKERP   analog   310.00m   2.06nH   0.86pF
D2   PWM1   gpio33s   406.00m   2.74nH   0.79pF
D3   LCD_D00   gpio33s   425.00m   2.56nH   0.65pF
D4   VSSA5   GND   122.00m   1.15nH   0.24pF
D5   VDDD1/3   POWER   190.00m   1.36nH   0.80pF
D6   VSSD1/5   GND   38.00m   0.42nH   1.01pF
D7   ROTARYA   gpio33s   664.00m   3.83nH   1.26pF
D8   VDDD1/3   POWER   190.00m   1.36nH   0.80pF
D9   LRADC3   analog   271.00m   1.54nH   0.79pF
D10   SSPI_DETECT   gpio33s   513.00m   3.16nH   0.96pF
D11   PWM3   gpio33s   406.00m   2.50nH   0.71pF
D12   SSPI_SCK   gpio33f   550.00m   4.36nH   0.79pF
D13   DCDC_VDDD   analog   256.00m   2.91nH   0.25pF
E1   LCD_D17   gpio33s   575.00m   3.08nH   0.53pF
E2   LCD_D01   gpio33s   506.00m   2.86nH   0.58pF
E3   LCD_D16   gpio33s   513.00m   2.72nH   0.66pF
E4   LCD_D02   gpio33s   371.00m   2.06nH   0.74pF
E5   LCD_D15   gpio33s   654.00m   3.39nH   0.78pF
E6   GPMI_DRDY3   gpio33s   847.00m   5.36nH   1.29pF
E7   GPMI_WRN   gpio33f   867.00m   5.39nH   1.30pF
E8   ROTARYB   gpio33s   993.00m   5.65nH   1.33pF
E9   VSSD1/5   GND   38.00m   0.42nH   1.01pF
E10   SSPI_DATA3   gpio33s   437.00m   2.68nH   0.82pF
E11   VDDIO33_1/2/3   POWER   100.00m   0.70nH   0.65pF
E12   DEBUG   gpio33s   465.00m   3.32nH   0.63pF
E13   VDD5V   POWER   348.00m   4.05nH   0.34pF
F1   LCD_D03   gpio33s   464.00m   3.03nH   0.53pF
F2   LCD_D14   gpio33s   521.00m   2.92nH   0.56pF
F3   LCD_D04   gpio33s   319.00m   1.83nH   0.56pF
F4   LCD_D13   gpio33s   619.00m   3.22nH   0.79pF
F5   LCD_D05   gpio33s   639.00m   3.36nH   0.86pF
F6   GPMI_DRDY2   gpio33s   779.00m   4.38nH   1.18pF
F7   GPMI_WPN   gpio33s   515.00m   2.89nH   1.10pF
F8   GPMI_CE1N   gpio33s   540.00m   3.19nH   0.98pF
F9   SSPI_DATA1   gpio33s   448.00m   2.48nH   0.77pF
F10   SSPI_DATA2   gpio33s   452.00m   2.35nH   0.78pF
F11   EMI_CKE   emi   652.00m   3.71nH   0.97pF
F12   EMI_A06   emi   621.00m   4.00nH   1.14pF
F13   EMI_A09   emi   855.00m   7.85nH   0.95pF
G1   LCD_D12   gpio33s   546.00m   3.48nH   0.56pF
G2   LCD_D06   gpio33s   529.00m   3.15nH   0.62pF
G3   VDDIO33_1/2/3   POWER   100.00m   0.70nH   0.65pF
G4   LCD_D11   gpio33s   363.00m   1.90nH   1.07pF
G5   LCD_D07   gpio33s   644.00m   3.30nH   0.83pF
G6   GPMI_RDY0   gpio33s   675.00m   3.54nH   1.07pF
G7   AUART1_CTS   gpio33s   460.00m   2.74nH   1.02pF
G8   GPMI_CE0N   gpio33s   566.00m   3.15nH   0.94pF
G9   SSPI_DATA0   gpio33s   428.00m   2.19nH   0.73pF
G10   EMI_A04   emi   619.00m   3.44nH   1.01pF
G11   EMI_A07   emi   428.00m   2.70nH   0.90pF
G12   EMI_A05   emi   454.00m   2.91nH   0.85pF
G13   EMI_A08   emi   809.00m   6.87nH   0.95pF
H1   LCD_D10   gpio33s   460.00m   3.18nH   0.58pF
H2   LCD_D08   gpio33s   516.00m   3.15nH   0.65pF
H3   LCD_D09   gpio33s   337.00m   2.08nH   0.61pF
H4   LCD_CS   gpio33s   554.00m   2.81nH   0.79pF
H5   LCD_ENABLE   gpio33s   727.00m   3.75nH   1.00pF
H6   GPMI_RDN   gpio33f   677.00m   3.51nH   1.11pF
H7   AUART1_RTS   gpio33s   414.00m   2.32nH   0.97pF
H8   AUART1_RX   gpio33s   734.00m   3.97nH   1.03pF
H9   SSPI_CMD   gpio33s   389.00m   2.08nH   0.72pF
H10   EMI_A11   emi   397.00m   2.18nH   0.90pF
H11   PWM2   gpio33s   512.00m   3.46nH   0.92pF
H12   EMI_CE1N   emi   552.00m   3.60nH   1.04pF
H13   EMI_A12   emi   687.00m   5.40nH   0.95pF
J1   LCD_VSYNC   gpio33s   565.00m   3.67nH   0.57pF
J2   LCD_HSYNC   gpio33s   527.00m   3.27nH   0.65pF
J3   LCD_RS   gpio33s   368.00m   2.22nH   0.69pF
J4   LCD_WR   gpio33s   668.00m   3.41nH   0.90pF
J5   LCD_RESET   gpio33s   485.00m   2.59nH   1.05pF
J6   GPMI_RDY1   gpio33s   427.00m   2.51nH   0.98pF
J7   VSSIO_EMI1/2   POWER   65.00m   0.39nH   0.28pF
J8   AUART1_TX   gpio33s   422.00m   2.53nH   1.01pF
J9   VSSIO_EMI1/2   GND   65.00m   0.39nH   0.28pF
J10   EMI_CE0N   emi   282.00m   1.47nH   0.86pF
J11   EMI_WEN   emi   390.00m   2.50nH   0.71pF
J12   EMI_A10   emi   472.00m   3.35nH   0.76pF
J13   EMI_A02   emi   454.00m   3.36nH   0.66pF
K1   LCD_DOTCK   gpio33f   614.00m   4.14nH   0.66pF
K2   GPMI_D00   gpio33s   553.00m   3.54nH   0.60pF
K3   GPMI_CLE   gpio33s   511.00m   2.83nH   0.75pF
K4   GPMI_ALE   gpio33s   360.00m   2.00nH   0.71pF
K5   GPMI_CE2N   gpio33s   653.00m   3.56nH   0.90pF
K6   EMI_D13   emi   767.00m   4.83nH   1.47pF
K7   EMI_D11   emi   547.00m   2.77nH   0.99pF
K8   EMI_DQS1   emiq   464.00m   2.58nH   0.73pF
K9   EMI_D05   emi   493.00m   2.66nH   1.08pF
K10   EMI_D00   emi   604.00m   3.73nH   0.99pF
K11   EMI_A03   emi   428.00m   2.68nH   0.73pF
K12   EMI_A01   emi   514.00m   3.59nH   0.74pF
K13   EMI_A00   emi   505.00m   3.82nH   0.66pF
L1   GPMI_D01   gpio33s   510.00m   3.92nH   0.63pF
L2   GPMI_D02   gpio33s   620.00m   4.17nH   0.70pF
L3   GPMI_D03   gpio33s   475.00m   3.31nH   0.81pF
L4   GPMI_D05   gpio33s   600.00m   3.93nH   1.21pF
L5   GPMI_D04   gpio33s   400.00m   2.47nH   1.02pF
L6   VDDIO_EMIQ   POWER   130.00m   1.11nH   0.21pF
L7   EMI_D12   emi   846.00m   5.64nH   1.53pF
L8   VDDIO_EMI1/2   POWER   75.00m   0.76nH   0.28pF
L9   EMI_D07   emi   448.00m   2.62nH   0.84pF
L10   VDDIO_EMI1/2   POWER   75.00m   0.76nH   0.28pF
L11   EMI_D06   emi   613.00m   4.15nH   0.88pF
L12   EMI_BA1   emi   608.00m   4.76nH   0.76pF
L13   EMI_BA0   emi   655.00m   5.19nH   0.74pF
M1   GPMI_D07   gpio33s   568.00m   4.17nH   0.74pF
M2   GPMI_D06   gpio33s   418.00m   3.33nH   0.76pF
M3   GPMI_D08   gpio33s   457.00m   3.45nH   0.70pF
M4   GPMI_D09   gpio33s   303.00m   2.16nH   0.77pF
M5   GPMI_D10   gpio33s   565.00m   4.22nH   0.90pF
M6   EMI_CLK   emiq   430.00m   2.51nH   0.51pF
M7   EMI_D15   emi   873.00m   5.83nH   1.05pF
M8   EMI_D10   emi   484.00m   2.83nH   0.82pF
M9   EMI_DQM1   emi   456.00m   2.55nH   0.77pF
M10   EMI_D01   emi   667.00m   4.78nH   0.83pF
M11   EMI_D04   emi   758.00m   5.73nH   1.02pF
M12   EMI_DQM0   emi   864.00m   6.57nH   1.03pF
M13   EMI_CASN   emi   605.00m   4.75nH   0.74pF
N1   GPMI_D11   gpio33s   671.00m   5.47nH   0.72pF
N2   GPMI_D12   gpio33s   631.00m   4.93nH   0.69pF
N3   GPMI_D13   gpio33s   633.00m   4.62nH   0.67pF
N4   GPMI_D14   gpio33s   561.00m   4.07nH   0.69pF
N5   GPMI_D15   gpio33s   630.00m   4.49nH   0.78pF
N6   EMI_CLKN   emiq   505.00m   3.91nH   0.52pF
N7   EMI_D14   emi   876.00m   6.30nH   1.07pF
N8   EMI_D09   emi   537.00m   3.66nH   0.92pF
N9   EMI_D08   emi   529.00m   3.48nH   0.91pF
N10   EMI_D03   emi   689.00m   5.66nH   0.83pF
N11   EMI_D02   emi   810.00m   6.45nH   0.93pF
N12   EMI_DQS0   emiq   887.00m   7.77nH   0.86pF
N13   EMI_RASN   emi   519.00m   4.67nH   0.69pF
|A1   USB_DM   hs_usb   485.50m   5.90nH   0.76pF
|A2   USB_DP   hs_usb   442.50m   5.25nH   0.71pF
|A3   REFP   analog   492.10m   5.58nH   0.68pF
|A4   XTALI   analog   406.20m   4.58nH   0.82pF
|A5   VAG   analog   430.70m   4.86nH   0.62pF
|A6   LINE1R   analog   420.50m   4.50nH   0.61pF
|A7   HP_VGND   analog   304.00m   4.03nH   0.70pF
|A8   LINE_RIGHT   analog   390.50m   4.45nH   0.67pF
|A9   LRADCO   analog   402.10m   4.67nH   0.61pF
|A10   LRADC2   analog   411.40m   4.96nH   0.60pF
|A11   BATT   analog   165.20m   4.21nH   0.77pF
|A12   DCDC_LN1   analog   167.00m   4.52nH   0.86pF
|A13   DCDC_GND   analog   172.60m   4.60nH   0.92pF
|B1   DEBUG   gpio   552.40m   6.07nH   0.73pF
|B2   TESTMODE   analog   434.10m   4.55nH   0.63pF
|B3   XTALO   analog   475.40m   4.83nH   0.75pF
|B4   RTC_XTALI   analog   343.50m   3.57nH   0.79pF
|B5   LlNE1L   analog   320.10m   3.36nH   0.66pF
|B6   MIC   analog   384.30m   4.18nH   0.70pF
|B7   HPL   analog   346.10m   3.68nH   0.67pF
|B8   HPR   analog   339.30m   3.71nH   0.70pF
|B9   LRADC1   analog   365.90m   4.22nH   0.64pF
|B10   LRADC3   analog   379.10m   4.39nH   0.71pF
|B11   DCDC_BATT   analog   119.30m   2.99nH   0.90pF
|B12   DCDC_LN2   analog   157.60m   4.39nH   0.97pF
|B13   DCDC_VDDIO   analog   151.00m   4.49nH   0.88pF
|C1   EMI_D15   emi   528.40m   5.52nH   0.66pF
|C2   EMI_D13   emi   397.30m   4.30nH   0.75pF
|C3   PSWITCH   analog   415.50m   4.51nH   0.79pF
|C4   RTC_XTALO   analog   325.10m   3.25nH   0.75pF
|C5   DCDC_MODE   analog   228.30m   2.42nH   0.70pF
|C6   HP_SENSE   analog   360.00m   3.35nH   0.78pF
|C7   LINE_LEFT   analog   326.50m   2.92nH   0.73pF
|C8   LINE_VAG   analog   336.00m   3.02nH   0.71pF
|C9   LRADC5   analog   344.40m   3.56nH   0.72pF
|C10   LRADC4   analog   427.20m   4.92nH   0.86pF
|C11   DCDC_LP   analog   119.50m   2.64nH   0.84pF
|C12   DCDC_VDDA   analog   139.00m   3.39nH   0.78pF
|C13   DCDC_VDDD   analog   146.70m   4.60nH   0.87pF
|D1   EMI_D11   emi   410.20m   4.68nH   0.64pF
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[Diff Pin]  inv_pin  vdiff   tdelay_typ  tdelay_min  tdelay_max
B2   A1   0.40V   0.000s
|   Model Selector
|  emi is DQ driver,  emiq is DQS/CLK driver
[Model Selector] gpio33s
gpio33s_1x  3.3V mode 4mA drive strength
gpio33s_2x  3.3V mode 8mA drive strength
gpio33s_3x  3.3V mode 12mA drive strength
[Model Selector] gpio33f
gpio33f_1x  3.3V mode 4mA drive strength
gpio33f_2x  3.3V mode 8mA drive strength
gpio33f_3x  3.3V mode 12mA drive strength
[Model Selector] emi
emi_18_1x   1.8V mode 4mA drive strength
emi_18_2x   1.8V mode 8mA drive strength
emi_18_3x   1.8V mode 12mA drive strength
emi_18_4x   1.8V mode 16mA drive strength
emi_25_1x   2.5V mode 4mA drive strength
emi_25_2x   2.5V mode 8mA drive strength
emi_25_3x   2.5V mode 12mA drive strength
emi_25_4x   2.5V mode 16mA drive strength
[Model Selector] emiq
emiq_18_1x   1.8V mode 4mA drive strength
emiq_18_2x   1.8V mode 8mA drive strength
emiq_18_3x   1.8V mode 12mA drive strength
emiq_18_4x   1.8V mode 16mA drive strength
emiq_25_1x   2.5V mode 4mA drive strength
emiq_25_2x   2.5V mode 8mA drive strength
emiq_25_3x   2.5V mode 12mA drive strength
emiq_25_4x   2.5V mode 16mA drive strength
| Models and submodels in the file (24): gpio33s_1x (I/O), gpio33s_2x (I/O), gpio33s_3x (I/O), gpio33f_1x (I/O), gpio33f_2x (I/O), gpio33f_3x (I/O), emi_18_1x (I/O), emi_18_2x (I/O), emi_18_3x (I/O), emi_18_4x (I/O), emiq_18_1x (I/O), emiq_18_2x (I/O), emiq_18_3x (I/O), emiq_18_4x (I/O), emi_25_1x (I/O), emi_25_2x (I/O), emi_25_3x (I/O), emi_25_4x (I/O), emiq_25_1x (I/O), emiq_25_2x (I/O), emiq_25_3x (I/O), emiq_25_4x (I/O), analog (Input), usb_hs (I/O)
